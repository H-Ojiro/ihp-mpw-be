** sch_path: /home/shr25031/ihp-mpw-be/TO_Apr2025/Mixer5GHz/xschem/INDUCTOR_L23.sch
.subckt INDUCTOR_L23 LB23 LA23
*.PININFO LB23:B LA23:B
XL23 LA23 LB23 VSUB inductor2 w=10u s=1 d=222u a=1.559918e-08 nr=2 m=1
.ends

** sch_path: /home/shr25031/ihp-mpw-be/TO_Apr2025/Mixer5GHz/xschem/INDUCTOR_TOP.sch
.subckt INDUCTOR_TOP LB41 LA42 LB42 LA43 LB43 LA44 LB44 LA41 LB31 LA31 LB21 LA21 LB22 LA22 LB32 LA32 LB33 LA33 LB23 LA23 LB24 LA24
+ LB34 LA34 LB11 LA11 LB12 LA12
*.PININFO LB41:B LA42:B LB42:B LA43:B LB43:B LA44:B LB44:B LA41:B LB31:B LA31:B LB21:B LA21:B LB22:B LA22:B LB32:B LA32:B LB33:B
*+ LA33:B LB23:B LA23:B LB24:B LA24:B LB34:B LA34:B LB11:B LA11:B LB12:B LA12:B
XL21 LA21 LB21 VSUB inductor2 w=10u s=10u d=222u a=1.609248e-08 nr=2 m=1
XL22 LA22 LB22 VSUB inductor2 w=5u s=10u d=222u a=7.81504e-09 nr=2 m=1
XL23 LA23 LB23 VSUB inductor2 w=10u s=5u d=222u a=1.586128e-08 nr=2 m=1
XL24 LA24 LB24 VSUB inductor2 w=5u s=5u d=222u a=7.69944e-09 nr=2 m=1
XL31 LA31 LB31 VSUB inductor2 w=10u s=10u d=222u a=2.612592e-08 nr=3 m=1
XL32 LA32 LB32 VSUB inductor2 w=5u s=10u d=222u a=1.246776e-08 nr=3 m=1
XL33 LA33 LB33 VSUB inductor2 w=10u s=5u d=222u a=2.528232e-08 nr=3 m=1
XL34 LA34 LB34 VSUB inductor2 w=5u s=5u d=222u a=1.204596e-08 nr=3 m=1
XL41 LA41 LB41 VSUB inductor2 w=10u s=10u d=222u a=3.748416e-08 nr=4 m=1
XL42 LA42 LB42 VSUB inductor2 w=5u s=10u d=222u a=1.761728e-08 nr=4 m=1
XL43 LA43 LB43 VSUB inductor2 w=10u s=5u d=222u a=3.569696e-08 nr=4 m=1
XL44 LA44 LB44 VSUB inductor2 w=5u s=5u d=222u a=1.672368e-08 nr=4 m=1
XL11 LA11 LB11 VSUB inductor2 w=10u s=10u d=222u a=8.28384e-09 nr=1 m=1
XL12 LA12 LB12 VSUB inductor2 w=5u s=10u d=222u a=4.05912e-09 nr=1 m=1
.ends

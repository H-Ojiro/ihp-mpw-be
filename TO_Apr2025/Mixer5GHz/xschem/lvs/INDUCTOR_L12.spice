** sch_path: /home/shr25031/ihp-mpw-be/TO_Apr2025/Mixer5GHz/xschem/INDUCTOR_L12.sch
.subckt INDUCTOR_L12 LB12 LA12
*.PININFO LB12:B LA12:B
XL12 LA12 LB12 VSUB inductor2 w=5u s=1 d=222u a=4.05912e-09 nr=1 m=1
.ends

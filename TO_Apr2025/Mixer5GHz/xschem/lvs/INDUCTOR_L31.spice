** sch_path: /home/shr25031/ihp-mpw-be/TO_Apr2025/Mixer5GHz/xschem/INDUCTOR_L31.sch
.subckt INDUCTOR_L31 LB31 LA31
*.PININFO LB31:B LA31:B
XL31 LA31 LB31 VSUB inductor2 w=10u s=1 d=222u a=2.556032e-08 nr=3 m=1
.ends

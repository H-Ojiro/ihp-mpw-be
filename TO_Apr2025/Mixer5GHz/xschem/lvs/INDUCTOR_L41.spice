** sch_path: /home/shr25031/ihp-mpw-be/TO_Apr2025/Mixer5GHz/xschem/INDUCTOR_L41.sch
.subckt INDUCTOR_L41 LB41 LA41
*.PININFO LB41:B LA41:B
XL41 LA41 LB41 VSUB inductor2 w=10u s=1 d=222u a=3.663576e-08 nr=4 m=1
.ends

** sch_path: /home/shr25031/ihp-mpw-be/TO_Apr2025/Mixer5GHz/xschem/INDUCTOR_L11.sch
.subckt INDUCTOR_L11 LB11 LA11
*.PININFO LB11:B LA11:B
XL11 LA11 LB11 VSUB inductor2 w=10u s=1 d=222u a=8.28384e-09 nr=1 m=1
.ends

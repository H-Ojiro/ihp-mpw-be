** sch_path: /home/shr25031/ihp-mpw-be/TO_Apr2025/160GHz_LNA/xschem/160GHz_LNA_pr724.sch
.subckt 160GHz_LNA_pr724 RF_INPUT GND VCC VBB1 RF_OUTPUT VBB2
*.PININFO RF_INPUT:I GND:B VCC:B VBB1:B RF_OUTPUT:O VBB2:B
C1 RF_INPUT net1 rfcmim w=10.0e-6 l=15.0e-6 wfeed=6.0e-6
Q1 net2 net1 GND npn13G2 a=6.3e-14 p=1.94e-06 le=900e-9 we=70.0n m=4
Rc1 net2 VCC 5.86045272969374 rsil w=7.5e-6 l=5.0e-6 m=1 b=0 $SUB=GND
Rb1 net1 VBB1 4471.30730050934 rhigh w=1.9e-6 l=6.0e-6 m=1 b=0 $SUB=GND
CDecap1 VBB1 GND cap_cmim w=20.0e-6 l=25.0e-6 m=2
CDecap2 VCC GND cap_cmim w=20.0e-6 l=25.0e-6 m=2
C2 net2 GND rfcmim w=32.0e-6 l=3.72e-6 wfeed=3.0e-6
C3 GND net3 rfcmim w=5.2e-6 l=2.4e-6 wfeed=3.0e-6
Rb2 net3 VBB1 3740.12450481041 rhigh w=1.9e-6 l=5.0e-6 m=1 b=0 $SUB=GND
CDecap3 VBB1 GND cap_cmim w=20.0e-6 l=25.0e-6 m=2
Q2 net4 net3 GND npn13G2 a=6.3e-14 p=1.94e-06 le=900e-9 we=70.0n m=4
Rc2 net4 VCC 5.86045272969374 rsil w=7.5e-6 l=5.0e-6 m=1 b=0 $SUB=GND
CDecap4 VCC GND cap_cmim w=20.0e-6 l=25.0e-6 m=2
C4 net4 GND rfcmim w=32.0e-6 l=3.72e-6 wfeed=3.0e-6
C5 GND net5 rfcmim w=7.6e-6 l=2.5e-6 wfeed=3.0e-6
Rb3 net5 VBB1 4471.30730050934 rhigh w=1.9e-6 l=6.0e-6 m=1 b=0 $SUB=GND
CDecap5 VBB1 GND cap_cmim w=20.0e-6 l=25.0e-6 m=2
Rc3 net6 VCC 5.86045272969374 rsil w=7.5e-6 l=5.0e-6 m=1 b=0 $SUB=GND
CDecap6 VCC GND cap_cmim w=20.0e-6 l=25.0e-6 m=2
Q3 net6 net5 GND npn13G2 a=6.3e-14 p=1.94e-06 le=900e-9 we=70.0n m=2
Rb4 net7 VBB2 4243.26530612245 rhigh w=2.0e-6 l=6.0e-6 m=1 b=0 $SUB=GND
CDecap7 VBB2 GND cap_cmim w=20.0e-6 l=25.0e-6 m=4
Rc4 net8 VCC 6.32649800266312 rsil w=7.5e-6 l=5.5e-6 m=1 b=0 $SUB=GND
CDecap8 VCC GND cap_cmim w=20.0e-6 l=25.0e-6 m=2
Q4 net8 net7 GND npn13G2 a=6.3e-14 p=1.94e-06 le=900e-9 we=70.0n m=2
C6 net6 GND rfcmim w=32.0e-6 l=12.5e-6 wfeed=3.0e-6
C7 GND net7 rfcmim w=5.1e-6 l=2.4e-6 wfeed=3.0e-6
C8 net8 GND rfcmim w=32.0e-6 l=6.2e-6 wfeed=3.0e-6
C9 GND RF_OUTPUT rfcmim w=3.2e-6 l=2.4e-6 wfeed=3.0e-6
.ends
